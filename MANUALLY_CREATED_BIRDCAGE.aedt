# Ansys Electronics Desktop project, version 2024.2
materials:
  vacuum: permittivity=1

design BirdcageDesign (HFSS, HFSS Terminal Network, model units mm)
variables:
  coil_radius = 70mm
  coil_height = 150mm
  rung_width = 10mm
  end_ring_width = 20mm
  num_rungs = 16
  end_ring_cap_gap = 2mm
  Segment_length1 = (2*pi*coil_radius/num_rungs) - end_ring_cap_gap
  ring_height = 10mm
  cap = 73.25pF
geometry:
  Rung1 = rectangle(corner=(coil_radius, -rung_width/2, -coil_height/2), y_size=rung_width, z_size=coil_height)
  TopRing1 = rectangle(corner=(coil_radius, -Segment_length1/2, coil_height/2), y_size=Segment_length1, z_size=ring_height)
  Rectangle2_1 = TopRing1.duplicate_along_line(step=(0mm, 0mm, -coil_height), total=2)
  Rectangle2_1.move(0mm, 0mm, -10mm)
  Rung2..Rung16 = Rung1.duplicate_around_axis(axis=Z, angle=22.5deg, total=16)
  Rectangle2_2..Rectangle2_16 = TopRing1.duplicate_around_axis(axis=Z, angle=22.5deg, total=16)
  Rectangle2_1_1..Rectangle2_1_15 = Rectangle2_1.duplicate_around_axis(axis=Z, angle=22.5deg, total=16)
  TopCap1 = polyline(xyz in mm: (58.509174, -40.485775, 85) (59.794471, -38.562193, 85) (59.794471, -38.562193, 75) (58.509174, -40.485775, 75) (58.509174, -40.485775, 85), closed, covered)
  TopCap1.scale(1, 1, 0.5)
  TopCap1.move(0mm, 0mm, 37.5mm)
  Port1 = polyline(xyz in mm: (38.562193, -59.794471, -77.5) (40.485775, -58.509174, -77.5) (40.485775, -58.509174, -75) (38.562193, -59.794471, -75) (38.562193, -59.794471, -77.5), closed, covered)
  Port2, Port3, Port4 = Port1.duplicate_around_axis(axis=Z, angle=90deg, total=4)
  TopCap2..TopCap16 = TopCap1.duplicate_around_axis(axis=Z, angle=22.5deg, total=16)
  BottomCap1 = TopCap1.duplicate_along_line(step=(0mm, 0mm, -159.95811mm), total=2)
  BottomCap2..BottomCap16 = BottomCap1.duplicate_around_axis(axis=Z, angle=22.5deg, total=16)
  BottomCap1.delete()
  TopCap1_1 = TopCap1.duplicate_along_line(step=(0mm, 0mm, -159.92014mm), total=2)
  Male_Head1 = component(Male_Head, 3D_Component_File_Path="<syslib>/3DComponents/HFSS/Human Body Exteriors/Male/Male_Head.a3dcomp")
  Head [humanaverage, oriented by NeckCS] = part_of(Male_Head1)
  Male_Head1.move(TranslateVectorX=1505.8076mm TranslateVectorY=-1475.2986mm TranslateVectorZ=0mm)
  Male_Head1.move(TranslateVectorX=338.02013mm TranslateVectorY=379.50838mm TranslateVectorZ=0mm)
  [Rung1, TopRing1, Rectangle2_1, Rung2..Rung16, Rectangle2_2..Rectangle2_16, Rectangle2_1_1..Rectangle2_1_15, TopCap1, Port1..Port4, TopCap2..TopCap16, BottomCap2..BottomCap16, TopCap1_1].scale(5, 5, 5)
  Male_Head1.move(TranslateVectorX=-201.87988mm TranslateVectorY=-530.78891mm TranslateVectorZ=0mm)
  Male_Head1.move(TranslateVectorX=-789.46383mm TranslateVectorY=0mm TranslateVectorZ=0mm)
  Male_Head1.move(TranslateVectorX=0mm TranslateVectorY=486.05222mm TranslateVectorZ=0mm)
  Male_Head1.move(TranslateVectorX=0mm TranslateVectorY=0mm TranslateVectorZ=-433.06345mm)
  Male_Head1.move(TranslateVectorX=0mm TranslateVectorY=0mm TranslateVectorZ=-825.20615mm)
  Male_Head1.move(TranslateVectorX=0mm TranslateVectorY=830.58778mm TranslateVectorZ=0mm)
  Male_Head1.move(TranslateVectorX=-538.3994mm TranslateVectorY=0mm TranslateVectorZ=0mm)
  Male_Head1.move(TranslateVectorX=0mm TranslateVectorY=0mm TranslateVectorZ=-395.96852mm)
  Male_Head1.move(TranslateVectorX=0mm TranslateVectorY=314.65525mm TranslateVectorZ=0mm)
  Male_Head1.move(TranslateVectorX=-270.73575mm TranslateVectorY=-2.6583861mm TranslateVectorZ=0mm)
  RadiatingSurface [vacuum] = region(absolute_offset=1567.3981mm on all sides)
boundaries and excitations:
  PerfE1: Perfect E Objects=[Rung1..Rung9, Rung11, Rung10, Rung12..Rung16, TopRing1, Rectangle2_1, Rectangle2_1_1..Rectangle2_1_15, Rectangle2_2, Rectangle2_5, Rectangle2_6, Rectangle2_7, Rectangle2_3, Rectangle2_4, Rectangle2_8..Rectangle2_16]
  LumpRLC2: Lumped RLC Objects=TopCap1 CurrentLine{(292.54587, -202.42888, 387.5) -> (298.97235, -192.81097, 387.5)} RLC_Type=Parallel Capacitance=cap
  LumpRLC3: Lumped RLC Objects=TopCap2 CurrentLine{(347.74332, -75.067436, 387.5) -> (350, -63.722339, 387.5)} RLC_Type=Parallel Capacitance=cap
  LumpRLC4: Lumped RLC Objects=TopCap3 CurrentLine{(350, 63.722339, 387.5) -> (347.74332, 75.067436, 387.5)} RLC_Type=Parallel Capacitance=cap
  LumpRLC5: Lumped RLC Objects=TopCap4 CurrentLine{(298.97235, 192.81097, 387.5) -> (292.54587, 202.42888, 387.5)} RLC_Type=Parallel Capacitance=cap
  LumpRLC6: Lumped RLC Objects=TopCap5 CurrentLine{(202.42888, 292.54587, 387.5) -> (192.81097, 298.97235, 387.5)} RLC_Type=Parallel Capacitance=63.4pF
  LumpRLC7: Lumped RLC Objects=TopCap6 CurrentLine{(75.067436, 347.74332, 387.5) -> (63.722339, 350, 387.5)} RLC_Type=Parallel Capacitance=cap
  LumpRLC8: Lumped RLC Objects=TopCap7 CurrentLine{(-63.722339, 350, 387.5) -> (-75.067436, 347.74332, 387.5)} RLC_Type=Parallel Capacitance=cap
  LumpRLC9: Lumped RLC Objects=TopCap8 CurrentLine{(-192.81097, 298.97235, 387.5) -> (-202.42888, 292.54587, 387.5)} RLC_Type=Parallel Capacitance=cap
  LumpRLC10: Lumped RLC Objects=TopCap9 CurrentLine{(-292.54587, 202.42888, 387.5) -> (-298.97235, 192.81097, 387.5)} RLC_Type=Parallel Capacitance=cap
  LumpRLC11: Lumped RLC Objects=TopCap10 CurrentLine{(-347.74332, 75.067436, 387.5) -> (-350, 63.722339, 387.5)} RLC_Type=Parallel Capacitance=cap
  LumpRLC12: Lumped RLC Objects=TopCap11 CurrentLine{(-350, -63.722339, 387.5) -> (-347.74332, -75.067436, 387.5)} RLC_Type=Parallel Capacitance=cap
  LumpRLC13: Lumped RLC Objects=TopCap12 CurrentLine{(-298.97235, -192.81097, 387.5) -> (-292.54587, -202.42888, 387.5)} RLC_Type=Parallel Capacitance=cap
  LumpRLC14: Lumped RLC Objects=TopCap13 CurrentLine{(-202.42888, -292.54587, 387.5) -> (-192.81097, -298.97235, 387.5)} RLC_Type=Parallel Capacitance=cap
  LumpRLC15: Lumped RLC Objects=TopCap14 CurrentLine{(-75.067436, -347.74332, 387.5) -> (-63.722339, -350, 387.5)} RLC_Type=Parallel Capacitance=cap
  LumpRLC16: Lumped RLC Objects=TopCap15 CurrentLine{(63.722339, -350, 387.5) -> (75.067436, -347.74332, 387.5)} RLC_Type=Parallel Capacitance=cap
  LumpRLC17: Lumped RLC Objects=TopCap16 CurrentLine{(192.81097, -298.97235, 387.5) -> (202.42888, -292.54587, 387.5)} RLC_Type=Parallel Capacitance=cap
  LumpRLC19: Lumped RLC Objects=BottomCap2 CurrentLine{(347.74332, -75.067436, -412.29057) -> (350, -63.722339, -412.29057)} RLC_Type=Parallel Capacitance=cap
  LumpRLC20: Lumped RLC Objects=BottomCap3 CurrentLine{(350, 63.722339, -412.29057) -> (347.74332, 75.067436, -412.29057)} RLC_Type=Parallel Capacitance=cap
  LumpRLC21: Lumped RLC Objects=BottomCap4 CurrentLine{(298.97235, 192.81097, -412.29057) -> (292.54587, 202.42888, -412.29057)} RLC_Type=Parallel Capacitance=cap
  LumpRLC22: Lumped RLC Objects=BottomCap5 CurrentLine{(202.42888, 292.54587, -412.29057) -> (192.81097, 298.97235, -412.29057)} RLC_Type=Parallel Capacitance=cap
  LumpRLC23: Lumped RLC Objects=BottomCap6 CurrentLine{(75.067436, 347.74332, -412.29057) -> (63.722339, 350, -412.29057)} RLC_Type=Parallel Capacitance=cap
  LumpRLC24: Lumped RLC Objects=BottomCap7 CurrentLine{(-63.722339, 350, -412.29057) -> (-75.067436, 347.74332, -412.29057)} RLC_Type=Parallel Capacitance=cap
  LumpRLC25: Lumped RLC Objects=BottomCap8 CurrentLine{(-192.81097, 298.97235, -412.29057) -> (-202.42888, 292.54587, -412.29057)} RLC_Type=Parallel Capacitance=cap
  LumpRLC26: Lumped RLC Objects=BottomCap9 CurrentLine{(-292.54587, 202.42888, -412.29057) -> (-298.97235, 192.81097, -412.29057)} RLC_Type=Parallel Capacitance=cap
  LumpRLC27: Lumped RLC Objects=BottomCap10 CurrentLine{(-347.74332, 75.067436, -412.29057) -> (-350, 63.722339, -412.29057)} RLC_Type=Parallel Capacitance=cap
  LumpRLC28: Lumped RLC Objects=BottomCap11 CurrentLine{(-350, -63.722339, -412.29057) -> (-347.74332, -75.067436, -412.29057)} RLC_Type=Parallel Capacitance=cap
  LumpRLC29: Lumped RLC Objects=BottomCap12 CurrentLine{(-298.97235, -192.81097, -412.29057) -> (-292.54587, -202.42888, -412.29057)} RLC_Type=Parallel Capacitance=cap
  LumpRLC30: Lumped RLC Objects=BottomCap13 CurrentLine{(-202.42888, -292.54587, -412.29057) -> (-192.81097, -298.97235, -412.29057)} RLC_Type=Parallel Capacitance=cap
  LumpRLC31: Lumped RLC Objects=BottomCap14 CurrentLine{(-75.067436, -347.74332, -412.29057) -> (-63.722339, -350, -412.29057)} RLC_Type=Parallel Capacitance=cap
  LumpRLC32: Lumped RLC Objects=BottomCap15 CurrentLine{(63.722339, -350, -412.29057) -> (75.067436, -347.74332, -412.29057)} RLC_Type=Parallel Capacitance=cap
  LumpRLC33: Lumped RLC Objects=BottomCap16 CurrentLine{(192.81097, -298.97235, -412.29057) -> (202.42888, -292.54587, -412.29057)} RLC_Type=Parallel Capacitance=cap
  LumpRLC34: Lumped RLC Objects=TopCap1_1 CurrentLine{(292.54587, -202.42888, -412.1007) -> (298.97235, -192.81097, -412.1007)} RLC_Type=Parallel Capacitance=cap
  Open1: Radiation Objects=RadiatingSurface
  Port1: Lumped Port Objects=Port1 LumpedPortType=Modal Modes{Mode1{IntLine{(192.81097, -298.97235, -381.25) -> (202.42888, -292.54587, -381.25)} CharImp=Zpi RenormImp=50ohm}} Impedance=50ohm
  Port2: Lumped Port Objects=Port2 LumpedPortType=Modal Modes{Mode1{IntLine{(298.97235, 192.81097, -381.25) -> (292.54587, 202.42888, -381.25)} CharImp=Zpi RenormImp=50ohm}} Impedance=50ohm
  Port3: Lumped Port Objects=Port3 LumpedPortType=Modal Modes{Mode1{IntLine{(-192.81097, 298.97235, -381.25) -> (-202.42888, 292.54587, -381.25)} CharImp=Zpi RenormImp=50ohm}} Impedance=50ohm
  Port4: Lumped Port Objects=Port4 LumpedPortType=Modal Modes{Mode1{IntLine{(-298.97235, -192.81097, -381.25) -> (-292.54587, -202.42888, -381.25)} CharImp=Zpi RenormImp=50ohm}} Impedance=50ohm
mesh:
  initial mesh: GlobalSurfApproximation{CurvedSurfaceApproxChoice=UseSlider SliderMeshSettings=1}
setups:
  Setup1: HfssDriven Frequency=63.8MHz MaxDeltaS=0.02 MaximumPasses=15 MinimumPasses=1 MinimumConvergedPasses=1 PercentRefinement=30 BasisOrder=0 DoLambdaRefine=false MaxTetIncrease=10000 PortAccuracy=2 DrivenSolverType="Direct Solver"
    sweep Sweep: 60MHz to 150MHz, 101 points; Type=Interpolating InterpTolerance=0.5 InterpMaxSolns=250 PassivityErrorTolerance=0.0001
source amplitudes:
  Port1:1: 1W 0deg
  Port2:1: 1W 90deg
  Port3:1: 1W 180deg
  Port4:1: 1W 270deg
radiation setups:
  3D: Infinite Sphere Theta=0deg..180deg step 2deg Phi=-180deg..180deg step 2deg
  Elevation: Infinite Sphere Theta=-180deg..180deg step 1deg Phi=0deg..90deg step 90deg
  Azimuth: Infinite Sphere Theta=90deg..90deg step 0deg Phi=-180deg..180deg step 1deg
reports:
  Terminal S Parameter Plot 1: dB(St(Port1,Port1)) vs Freq on Setup1 : Sweep

design Circuit2 (Circuit)
options: SParamCircuitDef IntegrationMethod=FFT
variables:
  cap = 64.23502pF  # optimise 25pF..75pF
components:
  S5 = BirdcageDesign3()
  cap = CAP_(C=cap)
  cap1 = CAP_(C=cap)
  cap2 = CAP_(C=cap)
  cap3 = CAP_(C=cap)
  cap4 = CAP_(C=cap)
  cap5 = CAP_(C=cap)
  cap6 = CAP_(C=cap)
  cap7 = CAP_(C=cap)
  cap8 = CAP_(C=cap)
  cap9 = CAP_(C=cap)
  cap10 = CAP_(C=cap)
  cap11 = CAP_(C=cap)
  cap12 = CAP_(C=cap)
  cap13 = CAP_(C=cap)
  cap14 = CAP_(C=cap)
  cap15 = CAP_(C=cap)
  cap16 = CAP_(C=cap)
  cap17 = CAP_(C=cap)
  cap18 = CAP_(C=cap)
  cap19 = CAP_(C=cap)
  cap20 = CAP_(C=cap)
  cap21 = CAP_(C=cap)
  cap22 = CAP_(C=cap)
  cap23 = CAP_(C=cap)
  cap24 = CAP_(C=cap)
  cap25 = CAP_(C=cap)
  cap26 = CAP_(C=cap)
  cap27 = CAP_(C=cap)
  cap28 = CAP_(C=cap)
  cap29 = CAP_(C=cap)
  cap30 = CAP_(C=cap)
  cap31 = CAP_(C=cap)
  port Port1 rz=50ohm iz=0ohm EnableNoise=false noisetemp=16.85cel
  port Port2 rz=50ohm iz=0ohm EnableNoise=false noisetemp=16.85cel
  port Port3 rz=50ohm iz=0ohm EnableNoise=false noisetemp=16.85cel
  port Port4 rz=50ohm iz=0ohm EnableNoise=false noisetemp=16.85cel
nets:
  0: cap6.0, cap7.0, cap8.0, cap3.0, cap.0, cap2.0, cap4.0, cap1.0, cap5.0, cap31.1, cap30.1, cap29.1, cap9.0, cap10.0, cap11.0, cap13.0, cap12.0, cap14.0, cap21.1, cap18.1, cap25.1, cap22.1, cap15.0, cap16.0, cap19.1, cap23.1, cap24.1, cap26.1, cap17.0, cap27.1, cap28.1, cap20.1
  net_10: cap2.1, S5.2
  net_11: cap3.1, S5.3
  net_12: S5.4, cap4.1
  net_13: S5.5, cap5.1
  net_14: cap6.1, S5.6
  net_15: cap7.1, S5.7
  net_16: cap8.1, S5.8
  net_17: S5.9, cap9.1
  net_18: S5.10, cap10.1
  net_19: S5.11, cap11.1
  net_20: S5.12, cap12.1
  net_21: S5.13, cap13.1
  net_22: S5.14, cap14.1
  net_23: S5.15, cap15.1
  net_24: S5.16, cap16.1
  net_25: S5.17, cap17.1
  net_26: S5.18, cap18.0
  net_27: S5.19, cap19.0
  net_28: S5.20, cap20.0
  net_29: S5.21, cap21.0
  net_30: S5.22, cap22.0
  net_31: S5.23, cap23.0
  net_32: S5.24, cap24.0
  net_33: S5.25, cap25.0
  net_34: S5.26, cap26.0
  net_35: S5.27, cap27.0
  net_36: S5.28, cap28.0
  net_37: S5.29, cap29.0
  net_38: S5.30, cap30.0
  net_39: S5.31, cap31.0
  net_7: cap.1, S5.0
  net_9: S5.1, cap1.1
  Port1: S5.32
  Port2: S5.33
  Port3: S5.34
  Port4: S5.35
setups:
  LinearFrequency: LinearFrequencyData(false, 0.1, false, "", false) SweepDefinition{Variable=Freq Data="LINC 60MHz 65MHz 100"}
optimetrics:
  OptimizationSetup1: Optimization UseFastCalculationUpdateAlgo Optimizer="Quasi Newton" AnalysisStopOptions{StopForNumIteration MaxNumIteration=1000 MinNumIteration=10} CostFuncNormType=L2 Acceptable_Cost=0 Noise=0.0001 UpdateDesignWhenDone
    vary cap: Min=5pF Max=150pF MinStep=0.5pF MaxStep=5pF MinFocus=25pF MaxFocus=75pF start=64.23502pF
    goal dB(S(Port1,Port1)) == -20 weight 1 on LinearFrequency : LinearFrequency at Freq 0.0638888888888889GHz
reports:
  S Parameter Plot 1: dB(S(Port1,Port1)) vs Freq on LinearFrequency : LinearFrequency
  S Parameter Plot 2: dB(S(Port1,Port1)) vs Freq on LinearFrequency : LinearFrequency
